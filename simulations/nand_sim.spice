** sch_path: /workspaces/usm-vlsi-tools/shared_xserver/Talleres/Taller2/Resuelto/nand_sim.sch
**.subckt nand_sim
XM1 net2 V1 Vout GND sg13_hv_nmos w=1.0u l=0.45u ng=1 m=1
XM2 Vout V1 net1 net1 sg13_hv_pmos w=1.0u l=0.45u ng=1 m=1
XM3 Vout V2 net1 net1 sg13_hv_pmos w=1.0u l=0.45u ng=1 m=1
XM4 GND V2 net2 GND sg13_hv_nmos w=1.0u l=0.45u ng=1 m=1
Vd net1 GND 3.3
Vin V1 GND PULSE(0 3.3 50n 100p 100p 50n 100n)
Vin1 V2 GND PULSE(0 3.3 100n 100p 100p 100n 200n)
**** begin user architecture code

.control
save all

tran 10p 270n
plot v(V1)+v(V2)
plot v(vout)
plot v(V1) v(V2)

meas tran fall_time Trig  v(V1) VAL=1.65 RISE=1 TARG v(Vout) VAL=1.65 FALL=1
meas tran rise_time Trig  v(V1) VAL=1.65 FALL=2 TARG v(Vout) VAL=1.65 RISE=1

.endc

.lib cornerMOShv.lib mos_tt

**** end user architecture code
**.ends
.GLOBAL GND
.end
